* Nested-subckt RC ladder -- generated by gsim-core 0.1.0 from model 'nested_ladder'
* Do not edit by hand: regenerate from the .gsim_sch document.

.subckt SECTION a b g
Rs a b 1000
Cs b g 1e-6
.ends SECTION

.subckt STAGE a b g
Xs1 a mid g SECTION
Xs2 mid b g SECTION
.ends STAGE

Vin VIN 0 5
Rload VOUT 0 10000

X1 VIN MID 0 STAGE
X2 MID VOUT 0 STAGE
