* Floating-reference resistor bank -- generated by gsim-core 0.1.0 from model 'floating_ref'
* Do not edit by hand: regenerate from the .gsim_sch document.

Vsrc TOP 0 12
Ra TOP MID 100
Rb MID 0 400
Rc MID 0 400
Rd MID 0 400
Re MID 0 400
Rf 0 SNUB 1000
Cf SNUB TOP 1e-7
