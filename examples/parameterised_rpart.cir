* Parameterised resistor subcircuit -- generated by gsim-core 0.9.0 from model 'parameterised_rpart'
* Do not edit by hand: regenerate from the .gsim_sch document.

.subckt RPART p n Rv=1000
R p n {Rv}
.ends RPART

Vin VIN 0 5

X1 VIN MID RPART Rv=100
X2 MID 0 RPART Rv=220
